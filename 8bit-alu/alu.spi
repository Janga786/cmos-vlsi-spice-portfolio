*** SPICE deck for cell 8bit_ALU_sim{sch} from library ENGR-338
*** Created on Tue Oct 14, 2025 09:26:11
*** Last revised on Mon Oct 27, 2025 16:10:37
*** Written on Mon Oct 27, 2025 16:10:53 by Electric VLSI Design System, version 9.08
*** Layout tech: mocmos, foundry MOSIS
*** UC SPICE *** , MIN_RESIST 4.0, MIN_CAPAC 0.1FF

*** SUBCIRCUIT ENGR-338__AND_Gate FROM CELL AND_Gate{sch}
.SUBCKT ENGR-338__AND_Gate A AandB B
** GLOBAL gnd
** GLOBAL vdd
Mnmos@0 net@1 A net@76 gnd NMOS L=0.6U W=3U
Mnmos@2 AandB net@1 gnd gnd NMOS L=0.6U W=3U
Mnmos@3 net@76 B gnd gnd NMOS L=0.6U W=3U
Mpmos@0 net@1 A vdd vdd PMOS L=0.6U W=3U
Mpmos@1 net@1 B vdd vdd PMOS L=0.6U W=3U
Mpmos@2 AandB net@1 vdd vdd PMOS L=0.6U W=6U
.ENDS ENGR-338__AND_Gate

*** SUBCIRCUIT ENGR-338__8bit_AND_Gate FROM CELL 8bit_AND_Gate{sch}
.SUBCKT ENGR-338__8bit_AND_Gate A[0] A[1] A[2] A[3] A[4] A[5] A[6] A[7] AandB[0] AandB[1] AandB[2] AandB[3] AandB[4] AandB[5] AandB[6] AandB[7] B[0] B[1] B[2] B[3] B[4] B[5] B[6] B[7]
** GLOBAL gnd
** GLOBAL vdd
XAND[0] A[0] AandB[0] B[0] ENGR-338__AND_Gate
XAND[1] A[1] AandB[1] B[1] ENGR-338__AND_Gate
XAND[2] A[2] AandB[2] B[2] ENGR-338__AND_Gate
XAND[3] A[3] AandB[3] B[3] ENGR-338__AND_Gate
XAND[4] A[4] AandB[4] B[4] ENGR-338__AND_Gate
XAND[5] A[5] AandB[5] B[5] ENGR-338__AND_Gate
XAND[6] A[6] AandB[6] B[6] ENGR-338__AND_Gate
XAND[7] A[7] AandB[7] B[7] ENGR-338__AND_Gate
.ENDS ENGR-338__8bit_AND_Gate

*** SUBCIRCUIT ENGR-338__High_Speed_FA FROM CELL High_Speed_FA{sch}
.SUBCKT ENGR-338__High_Speed_FA A B Cin Co S
** GLOBAL gnd
** GLOBAL vdd
Mnmos@0 Coi A net@27 gnd NMOS L=0.6U W=3U
Mnmos@1 net@27 B gnd gnd NMOS L=0.6U W=3U
Mnmos@2 Coi Cin net@28 gnd NMOS L=0.6U W=3U
Mnmos@3 net@28 A gnd gnd NMOS L=0.6U W=3U
Mnmos@4 net@28 B gnd gnd NMOS L=0.6U W=3U
Mnmos@5 Co Coi gnd gnd NMOS L=0.6U W=3U
Mnmos@6 net@89 A net@152 gnd NMOS L=0.6U W=3U
Mnmos@7 net@152 B net@151 gnd NMOS L=0.6U W=3U
Mnmos@8 net@151 Cin gnd gnd NMOS L=0.6U W=3U
Mnmos@9 net@89 Coi net@96 gnd NMOS L=0.6U W=3U
Mnmos@10 net@96 B gnd gnd NMOS L=0.6U W=3U
Mnmos@11 net@96 A gnd gnd NMOS L=0.6U W=3U
Mnmos@12 net@96 Cin gnd gnd NMOS L=0.6U W=3U
Mnmos@13 S net@89 gnd gnd NMOS L=0.6U W=3U
Mpmos@0 vdd A net@0 vdd PMOS L=0.6U W=3U
Mpmos@1 vdd B net@0 vdd PMOS L=0.6U W=3U
Mpmos@2 net@0 B net@11 vdd PMOS L=0.6U W=3U
Mpmos@3 net@11 A Coi vdd PMOS L=0.6U W=3U
Mpmos@4 net@0 Cin Coi vdd PMOS L=0.6U W=3U
Mpmos@5 vdd Coi Co vdd PMOS L=0.6U W=3U
Mpmos@6 vdd A net@79 vdd PMOS L=0.6U W=3U
Mpmos@7 vdd B net@79 vdd PMOS L=0.6U W=3U
Mpmos@8 vdd Cin net@79 vdd PMOS L=0.6U W=3U
Mpmos@9 net@79 A net@86 vdd PMOS L=0.6U W=3U
Mpmos@10 net@86 B net@87 vdd PMOS L=0.6U W=3U
Mpmos@11 net@87 Cin net@89 vdd PMOS L=0.6U W=3U
Mpmos@12 net@79 Coi net@89 vdd PMOS L=0.6U W=3U
Mpmos@13 vdd net@89 S vdd PMOS L=0.6U W=3U
.ENDS ENGR-338__High_Speed_FA

*** SUBCIRCUIT ENGR-338__8bit_High_Speed_FA FROM CELL 8bit_High_Speed_FA{sch}
.SUBCKT ENGR-338__8bit_High_Speed_FA A[0] A[1] A[2] A[3] A[4] A[5] A[6] A[7] B[0] B[1] B[2] B[3] B[4] B[5] B[6] B[7] Cin Co[0] Co[1] Co[2] Co[3] Co[4] Co[5] Co[6] Co[7] S[0] S[1] S[2] S[3] S[4] S[5] S[6] S[7]
** GLOBAL gnd
** GLOBAL vdd
XFA_HighS[0] A[0] B[0] Cin Co[0] S[0] ENGR-338__High_Speed_FA
XFA_HighS[1] A[1] B[1] Co[0] Co[1] S[1] ENGR-338__High_Speed_FA
XFA_HighS[2] A[2] B[2] Co[1] Co[2] S[2] ENGR-338__High_Speed_FA
XFA_HighS[3] A[3] B[3] Co[2] Co[3] S[3] ENGR-338__High_Speed_FA
XFA_HighS[4] A[4] B[4] Co[3] Co[4] S[4] ENGR-338__High_Speed_FA
XFA_HighS[5] A[5] B[5] Co[4] Co[5] S[5] ENGR-338__High_Speed_FA
XFA_HighS[6] A[6] B[6] Co[5] Co[6] S[6] ENGR-338__High_Speed_FA
XFA_HighS[7] A[7] B[7] Co[6] Co[7] S[7] ENGR-338__High_Speed_FA
.ENDS ENGR-338__8bit_High_Speed_FA

*** SUBCIRCUIT ENGR-338__MUX FROM CELL MUX{sch}
.SUBCKT ENGR-338__MUX A B S Si Y
** GLOBAL gnd
** GLOBAL vdd
Mnmos@0 A Si Y gnd NMOS L=0.6U W=3U
Mnmos@1 B S Y gnd NMOS L=0.6U W=3U
Mpmos@0 Y S A vdd PMOS L=0.6U W=3U
Mpmos@1 Y Si B vdd PMOS L=0.6U W=3U
.ENDS ENGR-338__MUX

*** SUBCIRCUIT ENGR-338__8bit_MUX FROM CELL 8bit_MUX{sch}
.SUBCKT ENGR-338__8bit_MUX A[0] A[1] A[2] A[3] A[4] A[5] A[6] A[7] B[0] B[1] B[2] B[3] B[4] B[5] B[6] B[7] S Si Y[0] Y[1] Y[2] Y[3] Y[4] Y[5] Y[6] Y[7]
** GLOBAL gnd
** GLOBAL vdd
XMUX[0] A[0] B[0] S Si Y[0] ENGR-338__MUX
XMUX[1] A[1] B[1] S Si Y[1] ENGR-338__MUX
XMUX[2] A[2] B[2] S Si Y[2] ENGR-338__MUX
XMUX[3] A[3] B[3] S Si Y[3] ENGR-338__MUX
XMUX[4] A[4] B[4] S Si Y[4] ENGR-338__MUX
XMUX[5] A[5] B[5] S Si Y[5] ENGR-338__MUX
XMUX[6] A[6] B[6] S Si Y[6] ENGR-338__MUX
XMUX[7] A[7] B[7] S Si Y[7] ENGR-338__MUX
.ENDS ENGR-338__8bit_MUX

*** SUBCIRCUIT ENGR-338__OR_Gate FROM CELL OR_Gate{sch}
.SUBCKT ENGR-338__OR_Gate A AorB B
** GLOBAL gnd
** GLOBAL vdd
Mnmos@0 net@5 A gnd gnd NMOS L=0.6U W=3U
Mnmos@1 net@5 B gnd gnd NMOS L=0.6U W=3U
Mnmos@2 AorB net@5 gnd gnd NMOS L=0.6U W=3U
Mpmos@0 vdd A net@18 vdd PMOS L=0.6U W=6U
Mpmos@1 net@18 B net@5 vdd PMOS L=0.6U W=6U
Mpmos@2 vdd net@5 AorB vdd PMOS L=0.6U W=6U
.ENDS ENGR-338__OR_Gate

*** SUBCIRCUIT ENGR-338__8bit_OR_Gate FROM CELL 8bit_OR_Gate{sch}
.SUBCKT ENGR-338__8bit_OR_Gate A[0] A[1] A[2] A[3] A[4] A[5] A[6] A[7] AorB[0] AorB[1] AorB[2] AorB[3] AorB[4] AorB[5] AorB[6] AorB[7] B[0] B[1] B[2] B[3] B[4] B[5] B[6] B[7]
** GLOBAL gnd
** GLOBAL vdd
XOR[0] A[0] AorB[0] B[0] ENGR-338__OR_Gate
XOR[1] A[1] AorB[1] B[1] ENGR-338__OR_Gate
XOR[2] A[2] AorB[2] B[2] ENGR-338__OR_Gate
XOR[3] A[3] AorB[3] B[3] ENGR-338__OR_Gate
XOR[4] A[4] AorB[4] B[4] ENGR-338__OR_Gate
XOR[5] A[5] AorB[5] B[5] ENGR-338__OR_Gate
XOR[6] A[6] AorB[6] B[6] ENGR-338__OR_Gate
XOR[7] A[7] AorB[7] B[7] ENGR-338__OR_Gate
.ENDS ENGR-338__8bit_OR_Gate

*** SUBCIRCUIT ENGR-338__Inverter_short FROM CELL Inverter_short{sch}
.SUBCKT ENGR-338__Inverter_short in out
** GLOBAL gnd
** GLOBAL vdd
Mnmos@1 out in gnd gnd NMOS L=0.6U W=3U
Mpmos@0 out in vdd vdd PMOS L=0.6U W=6U
.ENDS ENGR-338__Inverter_short

*** SUBCIRCUIT ENGR-338__8bit_inverter FROM CELL 8bit_inverter{sch}
.SUBCKT ENGR-338__8bit_inverter in[0] in[1] in[2] in[3] in[4] in[5] in[6] in[7] out[0] out[1] out[2] out[3] out[4] out[5] out[6] out[7]
** GLOBAL gnd
** GLOBAL vdd
XInverter[0] in[0] out[0] ENGR-338__Inverter_short
XInverter[1] in[1] out[1] ENGR-338__Inverter_short
XInverter[2] in[2] out[2] ENGR-338__Inverter_short
XInverter[3] in[3] out[3] ENGR-338__Inverter_short
XInverter[4] in[4] out[4] ENGR-338__Inverter_short
XInverter[5] in[5] out[5] ENGR-338__Inverter_short
XInverter[6] in[6] out[6] ENGR-338__Inverter_short
XInverter[7] in[7] out[7] ENGR-338__Inverter_short
.ENDS ENGR-338__8bit_inverter

*** SUBCIRCUIT ENGR-338__8bit_ALU FROM CELL 8bit_ALU{sch}
.SUBCKT ENGR-338__8bit_ALU A[0] A[1] A[2] A[3] A[4] A[5] A[6] A[7] B[0] B[1] B[2] B[3] B[4] B[5] B[6] B[7] Co[0] Co[1] Co[2] Co[3] Co[4] Co[5] Co[6] Co[7] S0 S1 S[0] S[1] S[2] S[3] S[4] S[5] S[6] S[7]
** GLOBAL gnd
** GLOBAL vdd
X_8bit_AND@0 B[0] B[1] B[2] B[3] B[4] B[5] B[6] B[7] net@35[7] net@35[6] net@35[5] net@35[4] net@35[3] net@35[2] net@35[1] net@35[0] A[0] A[1] A[2] A[3] A[4] A[5] A[6] A[7] ENGR-338__8bit_AND_Gate
X_8bit_Hig@0 A[0] A[1] A[2] A[3] A[4] A[5] A[6] A[7] net@11[7] net@11[6] net@11[5] net@11[4] net@11[3] net@11[2] net@11[1] net@11[0] S0 Co[0] Co[1] Co[2] Co[3] Co[4] Co[5] Co[6] Co[7] net@45[7] net@45[6] net@45[5] net@45[4] net@45[3] net@45[2] net@45[1] net@45[0] ENGR-338__8bit_High_Speed_FA
X_8bit_MUX@0 net@35[7] net@35[6] net@35[5] net@35[4] net@35[3] net@35[2] net@35[1] net@35[0] net@32[7] net@32[6] net@32[5] net@32[4] net@32[3] net@32[2] net@32[1] net@32[0] S0 net@49 net@48[7] net@48[6] net@48[5] net@48[4] net@48[3] net@48[2] net@48[1] net@48[0] ENGR-338__8bit_MUX
X_8bit_MUX@1 net@48[7] net@48[6] net@48[5] net@48[4] net@48[3] net@48[2] net@48[1] net@48[0] net@45[7] net@45[6] net@45[5] net@45[4] net@45[3] net@45[2] net@45[1] net@45[0] S1 net@99 S[0] S[1] S[2] S[3] S[4] S[5] S[6] S[7] ENGR-338__8bit_MUX
X_8bit_MUX@2 B[0] B[1] B[2] B[3] B[4] B[5] B[6] B[7] net@64[7] net@64[6] net@64[5] net@64[4] net@64[3] net@64[2] net@64[1] net@64[0] S0 net@4 net@11[7] net@11[6] net@11[5] net@11[4] net@11[3] net@11[2] net@11[1] net@11[0] ENGR-338__8bit_MUX
X_8bit_OR_@0 B[0] B[1] B[2] B[3] B[4] B[5] B[6] B[7] net@32[7] net@32[6] net@32[5] net@32[4] net@32[3] net@32[2] net@32[1] net@32[0] A[0] A[1] A[2] A[3] A[4] A[5] A[6] A[7] ENGR-338__8bit_OR_Gate
X_8bit_inv@0 B[0] B[1] B[2] B[3] B[4] B[5] B[6] B[7] net@64[7] net@64[6] net@64[5] net@64[4] net@64[3] net@64[2] net@64[1] net@64[0] ENGR-338__8bit_inverter
XInverter@0 S0 net@4 ENGR-338__Inverter_short
XInverter@1 S0 net@49 ENGR-338__Inverter_short
XInverter@2 S1 net@99 ENGR-338__Inverter_short
.ENDS ENGR-338__8bit_ALU

.global gnd vdd

*** TOP LEVEL CELL: 8bit_ALU_sim{sch}
X_8bit_ALU@0 vdd vdd vdd vdd vdd vdd vdd vdd vdd gnd gnd gnd gnd gnd gnd gnd Co[0] Co[1] Co[2] Co[3] Co[4] Co[5] Co[6] Co[7] S0 S1 S[0] S[1] S[2] S[3] S[4] S[5] S[6] S[7] ENGR-338__8bit_ALU

* Spice Code nodes in cell cell '8bit_ALU_sim{sch}'
vdd vdd 0 dc 5
V3 S1 0 dc 5
V4 s0 0 dc 5
.tran 0 80n
.options plotwinsize=0
.include C5_models.txt
.END
