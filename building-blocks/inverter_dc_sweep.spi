*** SPICE deck for cell Inverter{sch} from library ENGR-338
*** Created on Tue Sep 16, 2025 08:20:20
*** Last revised on Mon Sep 22, 2025 16:15:28
*** Written on Mon Sep 22, 2025 16:15:50 by Electric VLSI Design System, version 9.08
*** Layout tech: mocmos, foundry MOSIS
*** UC SPICE *** , MIN_RESIST 4.0, MIN_CAPAC 0.1FF

.global gnd vdd

*** TOP LEVEL CELL: Inverter{sch}
Mnmos@1 out in gnd gnd NMOS L=0.6U W=3U
Mpmos@0 out in vdd vdd PMOS L=0.6U W=6U
.END
