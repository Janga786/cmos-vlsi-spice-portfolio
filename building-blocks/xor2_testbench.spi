*** SPICE deck for cell XOR_Gate_test{sch} from library ENGR-338
*** Created on Tue Sep 23, 2025 09:41:21
*** Last revised on Tue Sep 23, 2025 10:18:48
*** Written on Tue Sep 23, 2025 10:18:58 by Electric VLSI Design System, version 9.08
*** Layout tech: mocmos, foundry MOSIS
*** UC SPICE *** , MIN_RESIST 4.0, MIN_CAPAC 0.1FF

*** SUBCIRCUIT ENGR-338__XOR_Gate FROM CELL XOR_Gate{sch}
.SUBCKT ENGR-338__XOR_Gate A B out
** GLOBAL gnd
** GLOBAL vdd
Mnmos@0 net@77 A gnd gnd NMOS L=0.6U W=3U
Mnmos@1 net@72 B gnd gnd NMOS L=0.6U W=3U
Mnmos@2 out net@77 net@90 gnd NMOS L=0.6U W=3U
Mnmos@3 out A net@89 gnd NMOS L=0.6U W=3U
Mnmos@4 net@90 net@72 gnd gnd NMOS L=0.6U W=3U
Mnmos@5 net@89 B gnd gnd NMOS L=0.6U W=3U
Mpmos@0 vdd A net@77 vdd PMOS L=0.6U W=6U
Mpmos@1 vdd B net@72 vdd PMOS L=0.6U W=6U
Mpmos@2 vdd B net@52 vdd PMOS L=0.6U W=6U
Mpmos@3 vdd A net@52 vdd PMOS L=0.6U W=6U
Mpmos@4 net@52 net@77 out vdd PMOS L=0.6U W=6U
Mpmos@5 net@52 net@72 out vdd PMOS L=0.6U W=6U
.ENDS ENGR-338__XOR_Gate

.global gnd vdd

*** TOP LEVEL CELL: XOR_Gate_test{sch}
Ccap@0 gnd out 0.1p
XXOR_Gate@0 in gnd out ENGR-338__XOR_Gate

* Spice Code nodes in cell cell 'XOR_Gate_test{sch}'
vdd vdd 0 dc 5
vin in 0 PULSE(0 5 10n 10p 10p 10n 21n)
.tran 0 40n
.include C5_models.txt
.END
